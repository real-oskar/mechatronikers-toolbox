.title KiCad schematic
C1 Net-_P3-P1_ GND 10u
P1 __P1
P3 __P3
U1 __U1
P4 __P4
P2 __P2
R4 Net-_P1-PM_ GND 47k
R2 Net-_U1B-K_ GND 1.5k
R3 Net-_P2-P1_ GND 100k
C2 Net-_P2-P1_ Net-_U1A-K_ 680n
R1 Net-_U1A-G_ Net-_U1A-K_ 1.5k
.end
